* NGSPICE file created from tt_um_Isaac_AND_IC_TopLevel.ext - technology: sky130A

.subckt sky130_fd_pr__nfet_01v8_648S5X a_n73_n100# a_n33_n188# a_15_n100# a_n175_n274#
X0 a_15_n100# a_n33_n188# a_n73_n100# a_n175_n274# sky130_fd_pr__nfet_01v8 ad=0.29 pd=2.58 as=0.29 ps=2.58 w=1 l=0.15
**devattr s=11600,516 d=11600,516
.ends

.subckt sky130_fd_pr__pfet_01v8_XGAKDL a_15_n200# w_n211_n419# a_n33_n297# a_n73_n200#
X0 a_15_n200# a_n33_n297# a_n73_n200# w_n211_n419# sky130_fd_pr__pfet_01v8 ad=0.58 pd=4.58 as=0.58 ps=4.58 w=2 l=0.15
**devattr s=23200,916 d=23200,916
.ends

.subckt ic_7804_AND A B Y VCC GND
XXM1 m1_1645_n1911# A m1_914_51# GND sky130_fd_pr__nfet_01v8_648S5X
XXM2 m1_914_51# VCC A VCC sky130_fd_pr__pfet_01v8_XGAKDL
XXM3 m1_914_51# VCC B VCC sky130_fd_pr__pfet_01v8_XGAKDL
XXM4 GND B m1_1645_n1911# GND sky130_fd_pr__nfet_01v8_648S5X
XXM5 Y VCC m1_914_51# VCC sky130_fd_pr__pfet_01v8_XGAKDL
XXM6 GND m1_914_51# Y GND sky130_fd_pr__nfet_01v8_648S5X
.ends

.subckt AND_IC_TopLevel 1A 1B 1Y 2B 2Y 3A 3B 3Y 4A 4B 4Y VCC 2A GND
Xx1 1A 1B 1Y VCC GND ic_7804_AND
Xx2 2A 2B 2Y VCC GND ic_7804_AND
Xx3 3A 3B 3Y VCC GND ic_7804_AND
Xx4 4A 4B 4Y VCC GND ic_7804_AND
.ends

.subckt tt_um_Isaac_AND_IC_TopLevel clk ena rst_n ui_in[0] ui_in[1] ui_in[2] ui_in[3]
+ ui_in[4] ui_in[5] ui_in[6] ui_in[7] uio_in[0] uio_in[1] uio_in[2] uio_in[3] uio_in[4]
+ uio_in[5] uio_in[6] uio_in[7] uio_oe[0] uio_oe[1] uio_oe[2] uio_oe[3] uio_oe[4]
+ uio_oe[5] uio_oe[6] uio_oe[7] uio_out[0] uio_out[1] uio_out[2] uio_out[3] uio_out[4]
+ uio_out[5] uio_out[6] uio_out[7] uo_out[0] uo_out[1] uo_out[2] uo_out[3] uo_out[4]
+ uo_out[5] uo_out[6] uo_out[7] VDPWR VGND
XAND_IC_TopLevel_0 ui_in[0] ui_in[1] uo_out[0] ui_in[3] uo_out[1] ui_in[4] ui_in[5]
+ uo_out[2] ui_in[6] ui_in[7] uo_out[3] VDPWR ui_in[2] VGND AND_IC_TopLevel
R0 VGND uio_oe[3] 0.000000
R1 VGND uio_out[6] 0.000000
R2 VGND uio_oe[2] 0.000000
R3 VGND uio_out[5] 0.000000
R4 VGND uio_oe[1] 0.000000
R5 VGND uio_out[4] 0.000000
R6 VGND uio_oe[0] 0.000000
R7 VGND uio_out[3] 0.000000
R8 VGND uio_out[2] 0.000000
R9 VGND uio_out[0] 0.000000
R10 VGND uio_out[1] 0.000000
R11 VGND uo_out[7] 0.000000
R12 VGND uio_oe[7] 0.000000
R13 VGND uo_out[6] 0.000000
R14 VGND uo_out[5] 0.000000
R15 VGND uio_oe[6] 0.000000
R16 VGND uio_oe[5] 0.000000
R17 VGND uo_out[4] 0.000000
R18 VGND uio_oe[4] 0.000000
R19 VGND uio_out[7] 0.000000
.ends
