* NGSPICE file created from sr_latch_parax.ext - technology: sky130A

.subckt sr_latch_parax s q r qb vss vdd
X0 qb.t0 r.t0 a_9320_n2869# vdd.t0 sky130_fd_pr__pfet_01v8 ad=0.435 pd=3.58 as=0.435 ps=3.58 w=1.5 l=0.15
X1 a_3320_n2869# s.t0 vdd.t5 vdd.t4 sky130_fd_pr__pfet_01v8 ad=0.435 pd=3.58 as=0.435 ps=3.58 w=1.5 l=0.15
X2 q.t2 qb.t3 vss.t5 vss.t4 sky130_fd_pr__nfet_01v8 ad=0.2175 pd=2.08 as=0.2175 ps=2.08 w=0.75 l=0.15
X3 qb.t1 r.t1 vss.t1 vss.t0 sky130_fd_pr__nfet_01v8 ad=0.2175 pd=2.08 as=0.2175 ps=2.08 w=0.75 l=0.15
X4 qb.t2 q.t3 vss.t7 vss.t6 sky130_fd_pr__nfet_01v8 ad=0.2175 pd=2.08 as=0.2175 ps=2.08 w=0.75 l=0.15
X5 q.t0 s.t1 vss.t3 vss.t2 sky130_fd_pr__nfet_01v8 ad=0.2175 pd=2.08 as=0.2175 ps=2.08 w=0.75 l=0.15
X6 q.t1 qb.t4 a_3320_n2869# vdd.t1 sky130_fd_pr__pfet_01v8 ad=0.435 pd=3.58 as=0.435 ps=3.58 w=1.5 l=0.15
X7 a_9320_n2869# q.t4 vdd.t3 vdd.t2 sky130_fd_pr__pfet_01v8 ad=0.435 pd=3.58 as=0.435 ps=3.58 w=1.5 l=0.15
R0 r.n0 r.t0 240.534
R1 r.n0 r.t1 173.127
R2 r r.n0 14.3061
R3 r.n1 r 0.293357
R4 r.n1 r 0.124159
R5 r r.n1 0.0634908
R6 qb.n0 qb.t4 240.534
R7 qb.n0 qb.t3 173.127
R8 qb.n3 qb.t0 169.244
R9 qb.n2 qb.t2 129.621
R10 qb.n2 qb.t1 126.838
R11 qb.n1 qb 26.8755
R12 qb.n4 qb 25.6553
R13 qb qb.n0 14.3067
R14 qb.n4 qb 12.5005
R15 qb qb.n3 5.64771
R16 qb.n3 qb.n2 0.581382
R17 qb.n4 qb.n1 0.274998
R18 qb.n1 qb 0.13555
R19 qb qb.n4 0.0633141
R20 vdd.n41 vdd.n35 1612.94
R21 vdd.n39 vdd.n38 1612.94
R22 vdd.n30 vdd.n24 1612.94
R23 vdd.n28 vdd.n27 1612.94
R24 vdd.n18 vdd.n12 1612.94
R25 vdd.n16 vdd.n15 1612.94
R26 vdd.n8 vdd.n2 1612.94
R27 vdd.n6 vdd.n5 1612.94
R28 vdd.n38 vdd.n37 191.542
R29 vdd.n41 vdd.n40 191.542
R30 vdd.n27 vdd.n26 191.542
R31 vdd.n30 vdd.n29 191.542
R32 vdd.n15 vdd.n14 191.542
R33 vdd.n18 vdd.n17 191.542
R34 vdd.n5 vdd.n4 191.542
R35 vdd.n8 vdd.n7 191.542
R36 vdd.n42 vdd.n34 172.048
R37 vdd.n36 vdd.n34 172.048
R38 vdd.n31 vdd.n25 172.048
R39 vdd.n25 vdd.n23 172.048
R40 vdd.n19 vdd.n13 172.048
R41 vdd.n13 vdd.n11 172.048
R42 vdd.n9 vdd.n1 172.048
R43 vdd.n3 vdd.n1 172.048
R44 vdd.n22 vdd.t3 168.894
R45 vdd.n44 vdd.t5 168.238
R46 vdd.n32 vdd.n31 165.662
R47 vdd.n32 vdd.n23 165.662
R48 vdd.n20 vdd.n19 165.662
R49 vdd.n20 vdd.n11 165.662
R50 vdd.n36 vdd.n33 164.415
R51 vdd.n3 vdd.n0 164.415
R52 vdd.n43 vdd.n42 163.882
R53 vdd.n10 vdd.n9 163.882
R54 vdd.n39 vdd.n34 92.5005
R55 vdd.n35 vdd.n33 92.5005
R56 vdd.n28 vdd.n25 92.5005
R57 vdd.n32 vdd.n24 92.5005
R58 vdd.n16 vdd.n13 92.5005
R59 vdd.n20 vdd.n12 92.5005
R60 vdd.n6 vdd.n1 92.5005
R61 vdd.n2 vdd.n0 92.5005
R62 vdd.n37 vdd.n35 77.0952
R63 vdd.n40 vdd.n39 77.0952
R64 vdd.n26 vdd.n24 77.0952
R65 vdd.n29 vdd.n28 77.0952
R66 vdd.n14 vdd.n12 77.0952
R67 vdd.n17 vdd.n16 77.0952
R68 vdd.n4 vdd.n2 77.0952
R69 vdd.n7 vdd.n6 77.0952
R70 vdd.n42 vdd.n41 26.4291
R71 vdd.n38 vdd.n36 26.4291
R72 vdd.n31 vdd.n30 26.4291
R73 vdd.n27 vdd.n23 26.4291
R74 vdd.n19 vdd.n18 26.4291
R75 vdd.n15 vdd.n11 26.4291
R76 vdd.n9 vdd.n8 26.4291
R77 vdd.n5 vdd.n3 26.4291
R78 vdd.n40 vdd.t4 10.9856
R79 vdd.n37 vdd.t4 10.9856
R80 vdd.n29 vdd.t1 10.9856
R81 vdd.n26 vdd.t1 10.9856
R82 vdd.n17 vdd.t0 10.9856
R83 vdd.n14 vdd.t0 10.9856
R84 vdd.n7 vdd.t2 10.9856
R85 vdd.n4 vdd.t2 10.9856
R86 vdd.n45 vdd.n43 9.56113
R87 vdd.n21 vdd.n10 9.56113
R88 vdd.n21 vdd.n20 5.54329
R89 vdd.n46 vdd.n32 4.91363
R90 vdd vdd.n46 0.635597
R91 vdd.n46 vdd.n45 0.630165
R92 vdd.n43 vdd.n33 0.22119
R93 vdd.n10 vdd.n0 0.22119
R94 vdd.n22 vdd.n21 0.193757
R95 vdd.n44 vdd 0.18618
R96 vdd.n45 vdd.n44 0.184416
R97 vdd vdd.n22 0.180599
R98 s.n0 s.t0 241.486
R99 s.n0 s.t1 172.714
R100 s s.n0 2.57145
R101 s.n1 s 0.406238
R102 s.n1 s 0.362375
R103 s.n2 s 0.0895288
R104 s s.n2 0.087375
R105 s.n2 s.n1 0.017075
R106 vss.n41 vss.n7 9300.06
R107 vss.n28 vss.n9 8632.8
R108 vss.n30 vss.n29 5349.28
R109 vss.n41 vss.n30 4489.68
R110 vss.n29 vss.n28 4465.3
R111 vss.n12 vss.n10 2161.21
R112 vss.n17 vss.n10 2161.21
R113 vss.n12 vss.n11 2161.21
R114 vss.n17 vss.n11 2161.21
R115 vss.n39 vss.n31 2161.21
R116 vss.n35 vss.n31 2161.21
R117 vss.n39 vss.n32 2161.21
R118 vss.n35 vss.n32 2161.21
R119 vss.n44 vss.n5 2161.21
R120 vss.n44 vss.n6 2161.21
R121 vss.n45 vss.n5 2161.21
R122 vss.n45 vss.n6 2161.21
R123 vss.n26 vss.n19 2161.21
R124 vss.n22 vss.n19 2161.21
R125 vss.n26 vss.n20 2161.21
R126 vss.n22 vss.n20 2161.21
R127 vss.n28 vss.n18 1395.9
R128 vss.n42 vss.n41 1395.9
R129 vss.n41 vss.n40 1381.74
R130 vss.n28 vss.n27 1381.74
R131 vss.t4 vss.n8 363.789
R132 vss.n18 vss.t4 363.789
R133 vss.t0 vss.n7 363.789
R134 vss.t0 vss.n42 363.789
R135 vss.n40 vss.t6 362.651
R136 vss.n34 vss.t6 362.651
R137 vss.n27 vss.t2 362.651
R138 vss.t2 vss.n9 362.651
R139 vss.n15 vss.n11 292.5
R140 vss.n11 vss.t4 292.5
R141 vss.n14 vss.n10 292.5
R142 vss.n10 vss.t4 292.5
R143 vss.n46 vss.n45 292.5
R144 vss.n45 vss.t0 292.5
R145 vss.n44 vss.n43 292.5
R146 vss.t0 vss.n44 292.5
R147 vss.n33 vss.n32 292.5
R148 vss.n32 vss.t6 292.5
R149 vss.n37 vss.n31 292.5
R150 vss.n31 vss.t6 292.5
R151 vss.n24 vss.n19 292.5
R152 vss.n19 vss.t2 292.5
R153 vss.n21 vss.n20 292.5
R154 vss.n20 vss.t2 292.5
R155 vss.n14 vss.n13 140.424
R156 vss.n16 vss.n14 140.424
R157 vss.n37 vss.n36 140.424
R158 vss.n38 vss.n37 140.424
R159 vss.n43 vss.n3 140.424
R160 vss.n43 vss.n4 140.424
R161 vss.n24 vss.n23 140.424
R162 vss.n25 vss.n24 140.424
R163 vss.n36 vss.n33 135.482
R164 vss.n23 vss.n21 135.482
R165 vss.n34 vss.n30 135.421
R166 vss.n38 vss.n2 134.996
R167 vss.n25 vss.n0 134.996
R168 vss.n16 vss.n15 134.149
R169 vss.n46 vss.n4 134.149
R170 vss.n13 vss.n1 133.633
R171 vss.n47 vss.n3 133.633
R172 vss.n29 vss.n8 122.031
R173 vss.n52 vss.t5 121.59
R174 vss.n48 vss.t1 121.59
R175 vss.n50 vss.t7 121.481
R176 vss.n54 vss.t3 121.481
R177 vss.n17 vss.n16 117.001
R178 vss.n18 vss.n17 117.001
R179 vss.n13 vss.n12 117.001
R180 vss.n12 vss.n8 117.001
R181 vss.n6 vss.n4 117.001
R182 vss.n42 vss.n6 117.001
R183 vss.n5 vss.n3 117.001
R184 vss.n7 vss.n5 117.001
R185 vss.n36 vss.n35 117.001
R186 vss.n35 vss.n34 117.001
R187 vss.n39 vss.n38 117.001
R188 vss.n40 vss.n39 117.001
R189 vss.n23 vss.n22 117.001
R190 vss.n22 vss.n9 117.001
R191 vss.n26 vss.n25 117.001
R192 vss.n27 vss.n26 117.001
R193 vss.n48 vss.n47 9.80051
R194 vss.n49 vss.n2 9.60653
R195 vss.n53 vss.n0 9.60653
R196 vss.n51 vss.n1 9.60438
R197 vss.n49 vss.n48 0.43101
R198 vss.n53 vss.n52 0.43101
R199 vss.n51 vss 0.274349
R200 vss.n33 vss.n2 0.267167
R201 vss.n21 vss.n0 0.267167
R202 vss.n15 vss.n1 0.237537
R203 vss.n47 vss.n46 0.237537
R204 vss vss.n50 0.197868
R205 vss vss.n54 0.197868
R206 vss.n52 vss.n51 0.196635
R207 vss.n50 vss.n49 0.179365
R208 vss.n54 vss.n53 0.179365
R209 q.n2 q.t4 241.486
R210 q.n2 q.t3 172.714
R211 q.n1 q.t1 169.244
R212 q.n0 q.t0 129.621
R213 q.n0 q.t2 126.838
R214 q q.n1 5.57584
R215 q.n3 q.n2 2.44645
R216 q.n4 q.n3 1.20417
R217 q.n1 q.n0 0.581382
R218 q.n5 q 0.5005
R219 q.n3 q 0.059875
R220 q.n4 q 0.011125
R221 q.n5 q.n4 0.00606931
R222 q q.n5 0.0055
C0 a_3320_n2869# qb 0.087498f
C1 q vdd 0.875797f
C2 a_3320_n2869# vdd 0.634328f
C3 a_3320_n2869# q 0.262549f
C4 r a_9320_n2869# 0.087498f
C5 a_9320_n2869# qb 0.262549f
C6 qb s 0.413527f
C7 a_9320_n2869# vdd 0.634328f
C8 s vdd 0.615025f
C9 a_9320_n2869# q 0.436493f
C10 r qb 1.11419f
C11 q s 0.390791f
C12 r vdd 0.421314f
C13 a_3320_n2869# s 0.436493f
C14 qb vdd 0.645639f
C15 r q 0.349653f
C16 q qb 1.65874f
C17 r vss 2.69185f
C18 q vss 4.88878f
C19 qb vss 12.008201f
C20 s vss 2.01426f
C21 vdd vss 13.5836f
C22 a_9320_n2869# vss 0.482268f
C23 a_3320_n2869# vss 0.482268f
.ends
