* NGSPICE file created from AND_IC_TopLevel_parax.ext - technology: sky130A

.subckt AND_IC_TopLevel_parax 1A 1B 1Y 2Y 3A 3B 3Y 4A 4Y VCC 2B 2A GND 4B
X0 1Y.t0 a_1507_n2149.t3 GND.t1 GND.t0 sky130_fd_pr__nfet_01v8 ad=0.29 pd=2.58 as=0.29 ps=2.58 w=1 l=0.15
X1 4Y.t1 a_1485_n12542.t3 VCC.t17 VCC.t16 sky130_fd_pr__pfet_01v8 ad=0.58 pd=4.58 as=0.58 ps=4.58 w=2 l=0.15
X2 a_1507_n2149.t0 1B.t0 VCC.t19 VCC.t18 sky130_fd_pr__pfet_01v8 ad=0.58 pd=4.58 as=0.58 ps=4.58 w=2 l=0.15
X3 a_1507_n2149.t2 1A.t0 VCC.t21 VCC.t20 sky130_fd_pr__pfet_01v8 ad=0.58 pd=4.58 as=0.58 ps=4.58 w=2 l=0.15
X4 a_1485_n12542.t1 4A.t0 a_2693_n11315# GND.t7 sky130_fd_pr__nfet_01v8 ad=0.29 pd=2.58 as=0.29 ps=2.58 w=1 l=0.15
X5 VCC.t9 3A.t0 a_15287_n12655.t2 VCC.t8 sky130_fd_pr__pfet_01v8 ad=0.58 pd=4.58 as=0.58 ps=4.58 w=2 l=0.15
X6 GND.t9 2B.t0 a_18585_n4542# GND.t8 sky130_fd_pr__nfet_01v8 ad=0.29 pd=2.58 as=0.29 ps=2.58 w=1 l=0.15
X7 VCC.t23 a_15287_n12655.t3 3Y.t1 VCC.t22 sky130_fd_pr__pfet_01v8 ad=0.58 pd=4.58 as=0.58 ps=4.58 w=2 l=0.15
X8 a_1507_n2149.t1 1A.t1 a_2715_n3176# GND.t17 sky130_fd_pr__nfet_01v8 ad=0.29 pd=2.58 as=0.29 ps=2.58 w=1 l=0.15
X9 GND.t19 a_15287_n12655.t4 3Y.t0 GND.t18 sky130_fd_pr__nfet_01v8 ad=0.29 pd=2.58 as=0.29 ps=2.58 w=1 l=0.15
X10 VCC.t3 3B.t0 a_15287_n12655.t0 VCC.t2 sky130_fd_pr__pfet_01v8 ad=0.58 pd=4.58 as=0.58 ps=4.58 w=2 l=0.15
X11 4Y.t0 a_1485_n12542.t4 GND.t12 GND.t11 sky130_fd_pr__nfet_01v8 ad=0.29 pd=2.58 as=0.29 ps=2.58 w=1 l=0.15
X12 a_1485_n12542.t0 4A.t1 VCC.t1 VCC.t0 sky130_fd_pr__pfet_01v8 ad=0.58 pd=4.58 as=0.58 ps=4.58 w=2 l=0.15
X13 GND.t14 a_15311_n2248.t3 2Y.t0 GND.t13 sky130_fd_pr__nfet_01v8 ad=0.29 pd=2.58 as=0.29 ps=2.58 w=1 l=0.15
X14 a_1485_n12542.t2 4B.t0 VCC.t15 VCC.t14 sky130_fd_pr__pfet_01v8 ad=0.58 pd=4.58 as=0.58 ps=4.58 w=2 l=0.15
X15 a_2715_n3176# 1B.t1 GND.t3 GND.t2 sky130_fd_pr__nfet_01v8 ad=0.29 pd=2.58 as=0.29 ps=2.58 w=1 l=0.15
X16 VCC.t11 2B.t1 a_15311_n2248.t2 VCC.t10 sky130_fd_pr__pfet_01v8 ad=0.58 pd=4.58 as=0.58 ps=4.58 w=2 l=0.15
X17 VCC.t13 a_15311_n2248.t4 2Y.t1 VCC.t12 sky130_fd_pr__pfet_01v8 ad=0.58 pd=4.58 as=0.58 ps=4.58 w=2 l=0.15
X18 GND.t5 3B.t1 a_18561_n9967# GND.t4 sky130_fd_pr__nfet_01v8 ad=0.29 pd=2.58 as=0.29 ps=2.58 w=1 l=0.15
X19 a_18561_n9967# 3A.t1 a_15287_n12655.t1 GND.t10 sky130_fd_pr__nfet_01v8 ad=0.29 pd=2.58 as=0.29 ps=2.58 w=1 l=0.15
X20 1Y.t1 a_1507_n2149.t4 VCC.t5 VCC.t4 sky130_fd_pr__pfet_01v8 ad=0.58 pd=4.58 as=0.58 ps=4.58 w=2 l=0.15
X21 VCC.t7 2A.t0 a_15311_n2248.t0 VCC.t6 sky130_fd_pr__pfet_01v8 ad=0.58 pd=4.58 as=0.58 ps=4.58 w=2 l=0.15
X22 a_18585_n4542# 2A.t1 a_15311_n2248.t1 GND.t6 sky130_fd_pr__nfet_01v8 ad=0.29 pd=2.58 as=0.29 ps=2.58 w=1 l=0.15
X23 a_2693_n11315# 4B.t1 GND.t16 GND.t15 sky130_fd_pr__nfet_01v8 ad=0.29 pd=2.58 as=0.29 ps=2.58 w=1 l=0.15
R0 a_1507_n2149.n0 a_1507_n2149.t4 278.937
R1 a_1507_n2149.n0 a_1507_n2149.t3 195.303
R2 a_1507_n2149.t0 a_1507_n2149.n2 117.428
R3 a_1507_n2149.n1 a_1507_n2149.t2 116.445
R4 a_1507_n2149.n1 a_1507_n2149.t1 88.8825
R5 a_1507_n2149.n2 a_1507_n2149.n0 11.0205
R6 a_1507_n2149.n2 a_1507_n2149.n1 5.59208
R7 GND.n152 GND.n13 94120.7
R8 GND.n93 GND.n47 18512.7
R9 GND.n47 GND.n12 18429.4
R10 GND.n96 GND.n94 15857.4
R11 GND.n99 GND.n96 12947.5
R12 GND.n53 GND.n13 11873.8
R13 GND.n74 GND.n73 9704.83
R14 GND.n74 GND.n43 9700.44
R15 GND.n94 GND.n93 8284.13
R16 GND.n152 GND.n12 8143.97
R17 GND.n73 GND.n53 4701.08
R18 GND.n99 GND.n43 4008.45
R19 GND.n76 GND.n47 2376.87
R20 GND.n75 GND.n74 2374.89
R21 GND.n107 GND.n100 2306.06
R22 GND.n103 GND.n100 2306.06
R23 GND.n107 GND.n101 2306.06
R24 GND.n103 GND.n101 2306.06
R25 GND.n116 GND.n110 2306.06
R26 GND.n116 GND.n112 2306.06
R27 GND.n110 GND.n95 2306.06
R28 GND.n112 GND.n95 2306.06
R29 GND.n97 GND.n39 2306.06
R30 GND.n125 GND.n39 2306.06
R31 GND.n97 GND.n41 2306.06
R32 GND.n125 GND.n41 2306.06
R33 GND.n80 GND.n77 2306.06
R34 GND.n84 GND.n77 2306.06
R35 GND.n80 GND.n78 2306.06
R36 GND.n84 GND.n78 2306.06
R37 GND.n118 GND.n44 2306.06
R38 GND.n122 GND.n44 2306.06
R39 GND.n118 GND.n45 2306.06
R40 GND.n122 GND.n45 2306.06
R41 GND.n27 GND.n23 2306.06
R42 GND.n31 GND.n23 2306.06
R43 GND.n27 GND.n24 2306.06
R44 GND.n31 GND.n24 2306.06
R45 GND.n65 GND.n59 2306.06
R46 GND.n65 GND.n60 2306.06
R47 GND.n59 GND.n58 2306.06
R48 GND.n60 GND.n58 2306.06
R49 GND.n20 GND.n9 2306.06
R50 GND.n154 GND.n9 2306.06
R51 GND.n20 GND.n10 2306.06
R52 GND.n154 GND.n10 2306.06
R53 GND.n143 GND.n22 2306.06
R54 GND.n139 GND.n22 2306.06
R55 GND.n143 GND.n33 2306.06
R56 GND.n139 GND.n33 2306.06
R57 GND.n67 GND.n55 2306.06
R58 GND.n71 GND.n55 2306.06
R59 GND.n67 GND.n56 2306.06
R60 GND.n71 GND.n56 2306.06
R61 GND.n146 GND.n15 2306.06
R62 GND.n150 GND.n15 2306.06
R63 GND.n146 GND.n16 2306.06
R64 GND.n150 GND.n16 2306.06
R65 GND.n91 GND.n49 2306.06
R66 GND.n87 GND.n49 2306.06
R67 GND.n91 GND.n50 2306.06
R68 GND.n87 GND.n50 2306.06
R69 GND.n53 GND.n11 1994.79
R70 GND.n26 GND.n12 899.885
R71 GND.n123 GND.n43 898.025
R72 GND.n14 GND.n13 593.573
R73 GND.n109 GND.n96 589.872
R74 GND.n73 GND.n72 450.634
R75 GND.n93 GND.n92 449.243
R76 GND.n148 GND.n16 292.5
R77 GND.t7 GND.n16 292.5
R78 GND.n18 GND.n15 292.5
R79 GND.t7 GND.n15 292.5
R80 GND.n69 GND.n56 292.5
R81 GND.t11 GND.n56 292.5
R82 GND.n57 GND.n55 292.5
R83 GND.t11 GND.n55 292.5
R84 GND.n141 GND.n33 292.5
R85 GND.n33 GND.t15 292.5
R86 GND.n34 GND.n22 292.5
R87 GND.t15 GND.n22 292.5
R88 GND.n10 GND.n7 292.5
R89 GND.t2 GND.n10 292.5
R90 GND.n9 GND.n8 292.5
R91 GND.t2 GND.n9 292.5
R92 GND.n61 GND.n58 292.5
R93 GND.t0 GND.n58 292.5
R94 GND.n65 GND.n64 292.5
R95 GND.t0 GND.n65 292.5
R96 GND.n25 GND.n24 292.5
R97 GND.n24 GND.t17 292.5
R98 GND.n29 GND.n23 292.5
R99 GND.n23 GND.t17 292.5
R100 GND.n120 GND.n45 292.5
R101 GND.t10 GND.n45 292.5
R102 GND.n46 GND.n44 292.5
R103 GND.t10 GND.n44 292.5
R104 GND.n82 GND.n78 292.5
R105 GND.n78 GND.t18 292.5
R106 GND.n79 GND.n77 292.5
R107 GND.n77 GND.t18 292.5
R108 GND.n41 GND.n40 292.5
R109 GND.t4 GND.n41 292.5
R110 GND.n127 GND.n39 292.5
R111 GND.t4 GND.n39 292.5
R112 GND.n95 GND.n1 292.5
R113 GND.t8 GND.n95 292.5
R114 GND.n116 GND.n115 292.5
R115 GND.t8 GND.n116 292.5
R116 GND.n102 GND.n101 292.5
R117 GND.n101 GND.t6 292.5
R118 GND.n105 GND.n100 292.5
R119 GND.n100 GND.t6 292.5
R120 GND.n89 GND.n49 292.5
R121 GND.t13 GND.n49 292.5
R122 GND.n51 GND.n50 292.5
R123 GND.t13 GND.n50 292.5
R124 GND.n106 GND.n105 149.835
R125 GND.n105 GND.n104 149.835
R126 GND.n115 GND.n113 149.835
R127 GND.n115 GND.n114 149.835
R128 GND.n64 GND.n63 149.835
R129 GND.n64 GND.n62 149.835
R130 GND.n30 GND.n29 149.835
R131 GND.n29 GND.n28 149.835
R132 GND.n19 GND.n8 149.835
R133 GND.n155 GND.n8 149.835
R134 GND.n83 GND.n82 149.835
R135 GND.n82 GND.n81 149.835
R136 GND.n121 GND.n120 149.835
R137 GND.n120 GND.n119 149.835
R138 GND.n126 GND.n40 149.835
R139 GND.n40 GND.n38 149.835
R140 GND.n141 GND.n140 149.835
R141 GND.n142 GND.n141 149.835
R142 GND.n70 GND.n69 149.835
R143 GND.n69 GND.n68 149.835
R144 GND.n148 GND.n147 149.835
R145 GND.n149 GND.n148 149.835
R146 GND.n89 GND.n88 149.835
R147 GND.n90 GND.n89 149.835
R148 GND.n104 GND.n102 142.969
R149 GND.n28 GND.n25 142.969
R150 GND.n121 GND.n46 142.969
R151 GND.n147 GND.n18 142.969
R152 GND.n114 GND.n1 142.805
R153 GND.n19 GND.n7 142.805
R154 GND.n127 GND.n126 142.805
R155 GND.n142 GND.n34 142.805
R156 GND.n113 GND.n1 142.69
R157 GND.n127 GND.n38 142.69
R158 GND.n156 GND.n155 142.429
R159 GND.n140 GND.n138 142.429
R160 GND.n62 GND.n61 142.028
R161 GND.n83 GND.n79 142.028
R162 GND.n68 GND.n57 142.028
R163 GND.n88 GND.n51 142.028
R164 GND.n106 GND.n2 141.976
R165 GND.n30 GND.n5 141.976
R166 GND.n119 GND.n37 141.976
R167 GND.n149 GND.n17 141.976
R168 GND.n63 GND.n4 141.512
R169 GND.n81 GND.n36 141.512
R170 GND.n70 GND.n35 141.512
R171 GND.n90 GND.n3 141.512
R172 GND.n150 GND.n149 117.001
R173 GND.n151 GND.n150 117.001
R174 GND.n147 GND.n146 117.001
R175 GND.n146 GND.n145 117.001
R176 GND.n71 GND.n70 117.001
R177 GND.n72 GND.n71 117.001
R178 GND.n68 GND.n67 117.001
R179 GND.n67 GND.n66 117.001
R180 GND.n140 GND.n139 117.001
R181 GND.n139 GND.n14 117.001
R182 GND.n143 GND.n142 117.001
R183 GND.n144 GND.n143 117.001
R184 GND.n155 GND.n154 117.001
R185 GND.n154 GND.n153 117.001
R186 GND.n20 GND.n19 117.001
R187 GND.n21 GND.n20 117.001
R188 GND.n63 GND.n60 117.001
R189 GND.n60 GND.n54 117.001
R190 GND.n62 GND.n59 117.001
R191 GND.n59 GND.n52 117.001
R192 GND.n31 GND.n30 117.001
R193 GND.n32 GND.n31 117.001
R194 GND.n28 GND.n27 117.001
R195 GND.n27 GND.n26 117.001
R196 GND.n122 GND.n121 117.001
R197 GND.n123 GND.n122 117.001
R198 GND.n119 GND.n118 117.001
R199 GND.n118 GND.n117 117.001
R200 GND.n84 GND.n83 117.001
R201 GND.n85 GND.n84 117.001
R202 GND.n81 GND.n80 117.001
R203 GND.n80 GND.n48 117.001
R204 GND.n126 GND.n125 117.001
R205 GND.n125 GND.n124 117.001
R206 GND.n97 GND.n38 117.001
R207 GND.n98 GND.n97 117.001
R208 GND.n114 GND.n112 117.001
R209 GND.n112 GND.n111 117.001
R210 GND.n113 GND.n110 117.001
R211 GND.n110 GND.n109 117.001
R212 GND.n104 GND.n103 117.001
R213 GND.n103 GND.n42 117.001
R214 GND.n107 GND.n106 117.001
R215 GND.n108 GND.n107 117.001
R216 GND.n88 GND.n87 117.001
R217 GND.n87 GND.n86 117.001
R218 GND.n91 GND.n90 117.001
R219 GND.n92 GND.n91 117.001
R220 GND.n165 GND.t9 90.9538
R221 GND.n6 GND.t3 90.9538
R222 GND.n128 GND.t5 90.9538
R223 GND.n136 GND.t16 90.9538
R224 GND.n159 GND.t1 85.4509
R225 GND.n134 GND.t12 85.4509
R226 GND.n162 GND.t14 85.4499
R227 GND.n131 GND.t19 85.4499
R228 GND.n66 GND.t0 62.6012
R229 GND.t11 GND.n54 62.6012
R230 GND.t13 GND.n48 61.6161
R231 GND.n86 GND.t18 61.6161
R232 GND.n144 GND.t17 56.157
R233 GND.t15 GND.n32 56.157
R234 GND.n117 GND.t8 55.1787
R235 GND.n111 GND.t10 55.1787
R236 GND.n163 GND.n2 20.6384
R237 GND.n158 GND.n5 20.6384
R238 GND.n130 GND.n37 20.6377
R239 GND.n135 GND.n17 20.6377
R240 GND.n75 GND.n52 17.0316
R241 GND.n85 GND.n76 16.0941
R242 GND.n93 GND.n43 11.0361
R243 GND.n92 GND.n48 11.0361
R244 GND.t18 GND.t13 11.0361
R245 GND.n86 GND.n85 11.0361
R246 GND.n66 GND.n52 10.1271
R247 GND.t0 GND.t11 10.1271
R248 GND.n72 GND.n54 10.1271
R249 GND.n73 GND.n12 10.1271
R250 GND.n26 GND.n21 6.44469
R251 GND.n145 GND.n144 6.44469
R252 GND.t2 GND.t17 6.44469
R253 GND.t15 GND.t7 6.44469
R254 GND.n151 GND.n14 6.44469
R255 GND.n109 GND.n108 6.43795
R256 GND.t8 GND.t6 6.43795
R257 GND.t10 GND.t4 6.43795
R258 GND.n111 GND.n42 6.43795
R259 GND.n124 GND.n123 6.43795
R260 GND.n160 GND.n4 5.39378
R261 GND.n132 GND.n36 5.39378
R262 GND.n133 GND.n35 5.39378
R263 GND.n161 GND.n3 5.39378
R264 GND.n129 GND.n127 4.82859
R265 GND.n138 GND.n137 4.82859
R266 GND.n164 GND.n1 4.82792
R267 GND.n157 GND.n156 4.82792
R268 GND.t4 GND.t6 4.59868
R269 GND.n124 GND.n42 4.59868
R270 GND.n76 GND.n75 4.47204
R271 GND.n161 GND.n160 4.4103
R272 GND.n133 GND.n132 4.40324
R273 GND.n153 GND.n11 4.14319
R274 GND.n98 GND.n94 4.13886
R275 GND.n145 GND.n21 3.68289
R276 GND.t7 GND.t2 3.68289
R277 GND.n108 GND.n99 3.21923
R278 GND.n152 GND.n151 2.7623
R279 GND.n32 GND.n11 2.302
R280 GND.n117 GND.n94 2.29959
R281 GND.n99 GND.n98 1.37995
R282 GND.n6 GND 0.984816
R283 GND.n136 GND 0.984816
R284 GND GND.n0 0.983865
R285 GND.n153 GND.n152 0.921098
R286 GND.n159 GND.n158 0.916375
R287 GND.n131 GND.n130 0.916375
R288 GND.n135 GND.n134 0.916375
R289 GND.n163 GND.n162 0.916375
R290 GND.n128 GND 0.889759
R291 GND GND.n165 0.889759
R292 GND GND.n0 0.871698
R293 GND.n102 GND.n2 0.5125
R294 GND.n25 GND.n5 0.5125
R295 GND.n46 GND.n37 0.5125
R296 GND.n18 GND.n17 0.5125
R297 GND.n130 GND.n129 0.442515
R298 GND.n164 GND.n163 0.442515
R299 GND.n158 GND.n157 0.44204
R300 GND.n137 GND.n135 0.44204
R301 GND.n0 GND 0.418751
R302 GND.n157 GND.n6 0.284721
R303 GND.n129 GND.n128 0.284721
R304 GND.n137 GND.n136 0.284721
R305 GND.n165 GND.n164 0.284721
R306 GND.n156 GND.n7 0.261724
R307 GND.n138 GND.n34 0.261724
R308 GND.n61 GND.n4 0.237537
R309 GND.n79 GND.n36 0.237537
R310 GND.n57 GND.n35 0.237537
R311 GND.n51 GND.n3 0.237537
R312 GND.n160 GND.n159 0.210576
R313 GND.n134 GND.n133 0.210576
R314 GND.n132 GND.n131 0.210101
R315 GND.n162 GND.n161 0.210101
R316 1Y.n0 1Y.t1 115.7
R317 1Y.n0 1Y.t0 85.9212
R318 1Y 1Y.n0 2.7055
R319 a_1485_n12542.n0 a_1485_n12542.t3 278.935
R320 a_1485_n12542.n0 a_1485_n12542.t4 195.304
R321 a_1485_n12542.n1 a_1485_n12542.t2 117.428
R322 a_1485_n12542.t0 a_1485_n12542.n2 116.445
R323 a_1485_n12542.n2 a_1485_n12542.t1 88.8825
R324 a_1485_n12542.n1 a_1485_n12542.n0 11.0194
R325 a_1485_n12542.n2 a_1485_n12542.n1 5.59208
R326 VCC.n133 VCC.n132 1789.41
R327 VCC.n135 VCC.n129 1789.41
R328 VCC.n122 VCC.n121 1789.41
R329 VCC.n124 VCC.n118 1789.41
R330 VCC.n112 VCC.n111 1789.41
R331 VCC.n114 VCC.n108 1789.41
R332 VCC.n102 VCC.n101 1789.41
R333 VCC.n104 VCC.n98 1789.41
R334 VCC.n91 VCC.n90 1789.41
R335 VCC.n93 VCC.n87 1789.41
R336 VCC.n80 VCC.n79 1789.41
R337 VCC.n82 VCC.n76 1789.41
R338 VCC.n39 VCC.n33 1789.41
R339 VCC.n37 VCC.n36 1789.41
R340 VCC.n49 VCC.n43 1789.41
R341 VCC.n47 VCC.n46 1789.41
R342 VCC.n60 VCC.n54 1789.41
R343 VCC.n58 VCC.n57 1789.41
R344 VCC.n7 VCC.n1 1789.41
R345 VCC.n5 VCC.n4 1789.41
R346 VCC.n18 VCC.n12 1789.41
R347 VCC.n16 VCC.n15 1789.41
R348 VCC.n29 VCC.n23 1789.41
R349 VCC.n27 VCC.n26 1789.41
R350 VCC.n136 VCC.n128 190.871
R351 VCC.n131 VCC.n128 190.871
R352 VCC.n125 VCC.n119 190.871
R353 VCC.n119 VCC.n117 190.871
R354 VCC.n115 VCC.n109 190.871
R355 VCC.n109 VCC.n107 190.871
R356 VCC.n105 VCC.n97 190.871
R357 VCC.n100 VCC.n97 190.871
R358 VCC.n94 VCC.n86 190.871
R359 VCC.n89 VCC.n86 190.871
R360 VCC.n83 VCC.n77 190.871
R361 VCC.n77 VCC.n75 190.871
R362 VCC.n40 VCC.n34 190.871
R363 VCC.n34 VCC.n32 190.871
R364 VCC.n50 VCC.n44 190.871
R365 VCC.n44 VCC.n42 190.871
R366 VCC.n61 VCC.n53 190.871
R367 VCC.n55 VCC.n53 190.871
R368 VCC.n8 VCC.n2 190.871
R369 VCC.n2 VCC.n0 190.871
R370 VCC.n19 VCC.n11 190.871
R371 VCC.n13 VCC.n11 190.871
R372 VCC.n30 VCC.n22 190.871
R373 VCC.n24 VCC.n22 190.871
R374 VCC.n131 VCC.n127 184.889
R375 VCC.n84 VCC.n83 184.889
R376 VCC.n55 VCC.n52 184.889
R377 VCC.n9 VCC.n8 184.889
R378 VCC.n84 VCC.n75 184.798
R379 VCC.n9 VCC.n0 184.798
R380 VCC.n100 VCC.n96 184.782
R381 VCC.n89 VCC.n85 184.782
R382 VCC.n13 VCC.n10 184.782
R383 VCC.n24 VCC.n21 184.782
R384 VCC.n126 VCC.n125 184.782
R385 VCC.n116 VCC.n115 184.782
R386 VCC.n41 VCC.n40 184.782
R387 VCC.n51 VCC.n50 184.782
R388 VCC.n126 VCC.n117 184.684
R389 VCC.n116 VCC.n107 184.684
R390 VCC.n41 VCC.n32 184.684
R391 VCC.n51 VCC.n42 184.684
R392 VCC.n137 VCC.n136 184.512
R393 VCC.n62 VCC.n61 184.512
R394 VCC.n106 VCC.n105 184.405
R395 VCC.n95 VCC.n94 184.405
R396 VCC.n20 VCC.n19 184.405
R397 VCC.n31 VCC.n30 184.405
R398 VCC.n135 VCC.n134 173.642
R399 VCC.n132 VCC.n130 173.642
R400 VCC.n124 VCC.n123 173.642
R401 VCC.n121 VCC.n120 173.642
R402 VCC.n114 VCC.n113 173.642
R403 VCC.n111 VCC.n110 173.642
R404 VCC.n104 VCC.n103 173.642
R405 VCC.n101 VCC.n99 173.642
R406 VCC.n93 VCC.n92 173.642
R407 VCC.n90 VCC.n88 173.642
R408 VCC.n82 VCC.n81 173.642
R409 VCC.n79 VCC.n78 173.642
R410 VCC.n36 VCC.n35 173.642
R411 VCC.n39 VCC.n38 173.642
R412 VCC.n46 VCC.n45 173.642
R413 VCC.n49 VCC.n48 173.642
R414 VCC.n57 VCC.n56 173.642
R415 VCC.n60 VCC.n59 173.642
R416 VCC.n4 VCC.n3 173.642
R417 VCC.n7 VCC.n6 173.642
R418 VCC.n15 VCC.n14 173.642
R419 VCC.n18 VCC.n17 173.642
R420 VCC.n26 VCC.n25 173.642
R421 VCC.n29 VCC.n28 173.642
R422 VCC.n138 VCC.t9 114.481
R423 VCC.n149 VCC.t1 114.481
R424 VCC.n63 VCC.t7 114.481
R425 VCC.n74 VCC.t21 114.481
R426 VCC.n145 VCC.t17 114.41
R427 VCC.n70 VCC.t5 114.41
R428 VCC.n142 VCC.t23 114.409
R429 VCC.n67 VCC.t13 114.409
R430 VCC.n140 VCC.t3 114.392
R431 VCC.n147 VCC.t15 114.392
R432 VCC.n65 VCC.t11 114.392
R433 VCC.n72 VCC.t19 114.392
R434 VCC.n133 VCC.n128 92.5005
R435 VCC.n129 VCC.n127 92.5005
R436 VCC.n122 VCC.n119 92.5005
R437 VCC.n126 VCC.n118 92.5005
R438 VCC.n112 VCC.n109 92.5005
R439 VCC.n116 VCC.n108 92.5005
R440 VCC.n102 VCC.n97 92.5005
R441 VCC.n98 VCC.n96 92.5005
R442 VCC.n91 VCC.n86 92.5005
R443 VCC.n87 VCC.n85 92.5005
R444 VCC.n80 VCC.n77 92.5005
R445 VCC.n84 VCC.n76 92.5005
R446 VCC.n37 VCC.n34 92.5005
R447 VCC.n41 VCC.n33 92.5005
R448 VCC.n47 VCC.n44 92.5005
R449 VCC.n51 VCC.n43 92.5005
R450 VCC.n58 VCC.n53 92.5005
R451 VCC.n54 VCC.n52 92.5005
R452 VCC.n5 VCC.n2 92.5005
R453 VCC.n9 VCC.n1 92.5005
R454 VCC.n16 VCC.n11 92.5005
R455 VCC.n12 VCC.n10 92.5005
R456 VCC.n27 VCC.n22 92.5005
R457 VCC.n23 VCC.n21 92.5005
R458 VCC.n134 VCC.n133 79.4196
R459 VCC.n130 VCC.n129 79.4196
R460 VCC.n123 VCC.n122 79.4196
R461 VCC.n120 VCC.n118 79.4196
R462 VCC.n113 VCC.n112 79.4196
R463 VCC.n110 VCC.n108 79.4196
R464 VCC.n103 VCC.n102 79.4196
R465 VCC.n99 VCC.n98 79.4196
R466 VCC.n92 VCC.n91 79.4196
R467 VCC.n88 VCC.n87 79.4196
R468 VCC.n81 VCC.n80 79.4196
R469 VCC.n78 VCC.n76 79.4196
R470 VCC.n35 VCC.n33 79.4196
R471 VCC.n38 VCC.n37 79.4196
R472 VCC.n45 VCC.n43 79.4196
R473 VCC.n48 VCC.n47 79.4196
R474 VCC.n56 VCC.n54 79.4196
R475 VCC.n59 VCC.n58 79.4196
R476 VCC.n3 VCC.n1 79.4196
R477 VCC.n6 VCC.n5 79.4196
R478 VCC.n14 VCC.n12 79.4196
R479 VCC.n17 VCC.n16 79.4196
R480 VCC.n25 VCC.n23 79.4196
R481 VCC.n28 VCC.n27 79.4196
R482 VCC.n136 VCC.n135 23.1255
R483 VCC.n132 VCC.n131 23.1255
R484 VCC.n125 VCC.n124 23.1255
R485 VCC.n121 VCC.n117 23.1255
R486 VCC.n115 VCC.n114 23.1255
R487 VCC.n111 VCC.n107 23.1255
R488 VCC.n105 VCC.n104 23.1255
R489 VCC.n101 VCC.n100 23.1255
R490 VCC.n94 VCC.n93 23.1255
R491 VCC.n90 VCC.n89 23.1255
R492 VCC.n83 VCC.n82 23.1255
R493 VCC.n79 VCC.n75 23.1255
R494 VCC.n40 VCC.n39 23.1255
R495 VCC.n36 VCC.n32 23.1255
R496 VCC.n50 VCC.n49 23.1255
R497 VCC.n46 VCC.n42 23.1255
R498 VCC.n61 VCC.n60 23.1255
R499 VCC.n57 VCC.n55 23.1255
R500 VCC.n8 VCC.n7 23.1255
R501 VCC.n4 VCC.n0 23.1255
R502 VCC.n19 VCC.n18 23.1255
R503 VCC.n15 VCC.n13 23.1255
R504 VCC.n30 VCC.n29 23.1255
R505 VCC.n26 VCC.n24 23.1255
R506 VCC.n150 VCC 9.35184
R507 VCC.n130 VCC.t8 8.97701
R508 VCC.n134 VCC.t8 8.97701
R509 VCC.n120 VCC.t2 8.97701
R510 VCC.n123 VCC.t2 8.97701
R511 VCC.n110 VCC.t22 8.97701
R512 VCC.n113 VCC.t22 8.97701
R513 VCC.n99 VCC.t16 8.97701
R514 VCC.n103 VCC.t16 8.97701
R515 VCC.n88 VCC.t14 8.97701
R516 VCC.n92 VCC.t14 8.97701
R517 VCC.n78 VCC.t0 8.97701
R518 VCC.n81 VCC.t0 8.97701
R519 VCC.n38 VCC.t12 8.97701
R520 VCC.n35 VCC.t12 8.97701
R521 VCC.n48 VCC.t10 8.97701
R522 VCC.n45 VCC.t10 8.97701
R523 VCC.n59 VCC.t6 8.97701
R524 VCC.n56 VCC.t6 8.97701
R525 VCC.n6 VCC.t20 8.97701
R526 VCC.n3 VCC.t20 8.97701
R527 VCC.n17 VCC.t18 8.97701
R528 VCC.n14 VCC.t18 8.97701
R529 VCC.n28 VCC.t4 8.97701
R530 VCC.n25 VCC.t4 8.97701
R531 VCC.n64 VCC.n62 4.98617
R532 VCC.n73 VCC.n9 4.98617
R533 VCC.n139 VCC.n137 4.98547
R534 VCC.n148 VCC.n84 4.98547
R535 VCC.n141 VCC.n126 4.97495
R536 VCC.n146 VCC.n95 4.97495
R537 VCC.n66 VCC.n51 4.97495
R538 VCC.n71 VCC.n20 4.97495
R539 VCC.n143 VCC.n116 4.97319
R540 VCC.n144 VCC.n106 4.97319
R541 VCC.n68 VCC.n41 4.97319
R542 VCC.n69 VCC.n31 4.97319
R543 VCC.n69 VCC.n68 4.75811
R544 VCC.n144 VCC.n143 4.75043
R545 VCC VCC.n150 3.15099
R546 VCC.n142 VCC.n141 0.985582
R547 VCC.n146 VCC.n145 0.985582
R548 VCC.n67 VCC.n66 0.985582
R549 VCC.n71 VCC.n70 0.985582
R550 VCC.n140 VCC.n139 0.963463
R551 VCC.n148 VCC.n147 0.963463
R552 VCC.n65 VCC.n64 0.963463
R553 VCC.n73 VCC.n72 0.963463
R554 VCC.n150 VCC 0.521591
R555 VCC VCC.n149 0.496385
R556 VCC VCC.n74 0.493711
R557 VCC.n138 VCC 0.393504
R558 VCC.n63 VCC 0.393504
R559 VCC.n137 VCC.n127 0.284944
R560 VCC.n62 VCC.n52 0.284944
R561 VCC.n106 VCC.n96 0.278761
R562 VCC.n95 VCC.n85 0.278761
R563 VCC.n20 VCC.n10 0.278761
R564 VCC.n31 VCC.n21 0.278761
R565 VCC.n139 VCC.n138 0.218607
R566 VCC.n149 VCC.n148 0.218607
R567 VCC.n64 VCC.n63 0.218607
R568 VCC.n74 VCC.n73 0.218607
R569 VCC.n145 VCC.n144 0.215006
R570 VCC.n70 VCC.n69 0.215006
R571 VCC.n143 VCC.n142 0.214492
R572 VCC.n68 VCC.n67 0.214492
R573 VCC.n141 VCC.n140 0.203175
R574 VCC.n66 VCC.n65 0.203175
R575 VCC.n147 VCC.n146 0.20266
R576 VCC.n72 VCC.n71 0.20266
R577 4Y.n0 4Y.t1 115.701
R578 4Y.n0 4Y.t0 85.9202
R579 4Y 4Y.n0 2.7055
R580 1B.n0 1B.t0 293.096
R581 1B.n0 1B.t1 197.579
R582 1B.n1 1B 20.5005
R583 1B 1B.n0 2.18143
R584 1B.n1 1B 0.517319
R585 1B 1B.n1 0.103
R586 1B.n1 1B 0.103
R587 1A.n0 1A.t0 280.707
R588 1A.n0 1A.t1 193.052
R589 1A 1A.n0 1.14729
R590 4A.n0 4A.t1 280.695
R591 4A.n0 4A.t0 192.988
R592 4A 4A.n0 1.14729
R593 3A.n0 3A.t0 280.707
R594 3A.n0 3A.t1 193.052
R595 3A 3A.n0 1.02229
R596 a_15287_n12655.n1 a_15287_n12655.t3 278.935
R597 a_15287_n12655.n1 a_15287_n12655.t4 195.304
R598 a_15287_n12655.t0 a_15287_n12655.n2 117.428
R599 a_15287_n12655.n0 a_15287_n12655.t2 116.447
R600 a_15287_n12655.n0 a_15287_n12655.t1 88.884
R601 a_15287_n12655.n2 a_15287_n12655.n1 11.0194
R602 a_15287_n12655.n2 a_15287_n12655.n0 5.58988
R603 2B.n1 2B.t1 293.098
R604 2B.n1 2B.t0 197.579
R605 2B 2B.n1 2.05836
R606 2B.n0 2B 0.2505
R607 2B.n0 2B 0.2505
R608 2B.n0 2B 0.0655255
R609 2B 2B.n0 0.00175
R610 3Y.n0 3Y.t1 115.701
R611 3Y.n0 3Y.t0 85.9212
R612 3Y 3Y.n0 2.8295
R613 3B.n0 3B.t0 293.099
R614 3B.n0 3B.t1 197.579
R615 3B 3B.n0 2.05836
R616 a_15311_n2248.n0 a_15311_n2248.t4 278.937
R617 a_15311_n2248.n0 a_15311_n2248.t3 195.304
R618 a_15311_n2248.n1 a_15311_n2248.t2 117.428
R619 a_15311_n2248.t0 a_15311_n2248.n2 116.447
R620 a_15311_n2248.n2 a_15311_n2248.t1 88.884
R621 a_15311_n2248.n1 a_15311_n2248.n0 11.0205
R622 a_15311_n2248.n2 a_15311_n2248.n1 5.58988
R623 2Y.n0 2Y.t1 115.701
R624 2Y.n0 2Y.t0 85.9222
R625 2Y 2Y.n0 2.8295
R626 4B.n0 4B.t0 293.099
R627 4B.n0 4B.t1 197.579
R628 4B.n1 4B 10.2505
R629 4B 4B.n0 2.18143
R630 4B.n1 4B 0.523514
R631 4B 4B.n1 0.103
R632 4B.n1 4B 0.103
R633 2A.n0 2A.t0 280.707
R634 2A.n0 2A.t1 193.052
R635 2A 2A.n0 1.02229
C0 4Y VCC 0.580573f
C1 2A VCC 0.503082f
C2 2B VCC 0.48713f
C3 3A 3B 0.100869f
C4 1B VCC 0.48713f
C5 a_2715_n3176# 1A 0.390134f
C6 3A VCC 0.503082f
C7 3B VCC 0.48713f
C8 3A a_18561_n9967# 0.390134f
C9 2Y VCC 0.582891f
C10 3B a_18561_n9967# 0.345588f
C11 1Y VCC 0.580351f
C12 3Y VCC 0.582307f
C13 1B 1A 0.106015f
C14 a_2693_n11315# 4B 0.345588f
C15 VCC 4B 0.48713f
C16 2A a_18585_n4542# 0.390134f
C17 2B a_18585_n4542# 0.345588f
C18 a_2715_n3176# 1B 0.345588f
C19 2A 2B 0.099323f
C20 4A a_2693_n11315# 0.390134f
C21 4A VCC 0.503082f
C22 1A VCC 0.503082f
C23 4A 4B 0.106487f
C24 3A GND 2.29389f
C25 4A GND 2.34932f
C26 3Y GND 2.43498f
C27 4Y GND 2.40886f
C28 3B GND 4.293f
C29 4B GND 4.35269f
C30 2A GND 2.28301f
C31 2B GND 4.27698f
C32 2Y GND 2.4456f
C33 1Y GND 2.39901f
C34 1B GND 4.34745f
C35 1A GND 2.34292f
C36 VCC GND 64.55115f
C37 a_18561_n9967# GND 1.40556f
C38 a_2693_n11315# GND 1.40556f
C39 a_18585_n4542# GND 1.40556f
C40 a_2715_n3176# GND 1.40556f
C41 a_15311_n2248.t2 GND 0.053229f
C42 a_15311_n2248.t3 GND 0.02907f
C43 a_15311_n2248.t4 GND 0.027802f
C44 a_15311_n2248.n0 GND 0.762933f
C45 a_15311_n2248.n1 GND 0.693218f
C46 a_15311_n2248.t1 GND 0.036785f
C47 a_15311_n2248.n2 GND 0.844057f
C48 a_15311_n2248.t0 GND 0.052907f
C49 a_15287_n12655.t2 GND 0.052907f
C50 a_15287_n12655.t1 GND 0.036785f
C51 a_15287_n12655.n0 GND 0.844057f
C52 a_15287_n12655.t4 GND 0.029073f
C53 a_15287_n12655.t3 GND 0.027802f
C54 a_15287_n12655.n1 GND 0.762929f
C55 a_15287_n12655.n2 GND 0.693218f
C56 a_15287_n12655.t0 GND 0.053229f
C57 VCC.t21 GND 0.008275f
C58 VCC.n0 GND 0.006508f
C59 VCC.n1 GND 0.006755f
C60 VCC.n2 GND 0.006755f
C61 VCC.t20 GND 0.059068f
C62 VCC.n4 GND 0.043286f
C63 VCC.n5 GND 0.006755f
C64 VCC.n7 GND 0.043286f
C65 VCC.n8 GND 0.006509f
C66 VCC.n9 GND 0.008672f
C67 VCC.t19 GND 0.008258f
C68 VCC.n10 GND 0.00375f
C69 VCC.n11 GND 0.006755f
C70 VCC.n12 GND 0.006755f
C71 VCC.t18 GND 0.059068f
C72 VCC.n13 GND 0.006506f
C73 VCC.n15 GND 0.043286f
C74 VCC.n16 GND 0.006755f
C75 VCC.n18 GND 0.043286f
C76 VCC.n19 GND 0.0065f
C77 VCC.n20 GND 0.004935f
C78 VCC.t5 GND 0.008275f
C79 VCC.n21 GND 0.00375f
C80 VCC.n22 GND 0.006755f
C81 VCC.n23 GND 0.006755f
C82 VCC.t4 GND 0.059068f
C83 VCC.n24 GND 0.006506f
C84 VCC.n26 GND 0.043286f
C85 VCC.n27 GND 0.006755f
C86 VCC.n29 GND 0.043286f
C87 VCC.n30 GND 0.0065f
C88 VCC.n31 GND 0.004976f
C89 VCC.n32 GND 0.006505f
C90 VCC.n33 GND 0.006755f
C91 VCC.n34 GND 0.006755f
C92 VCC.t12 GND 0.059068f
C93 VCC.n36 GND 0.043286f
C94 VCC.n37 GND 0.006755f
C95 VCC.n39 GND 0.043286f
C96 VCC.n40 GND 0.006506f
C97 VCC.n41 GND 0.00872f
C98 VCC.t13 GND 0.008275f
C99 VCC.n42 GND 0.006505f
C100 VCC.n43 GND 0.006755f
C101 VCC.n44 GND 0.006755f
C102 VCC.t10 GND 0.059068f
C103 VCC.n46 GND 0.043286f
C104 VCC.n47 GND 0.006755f
C105 VCC.n49 GND 0.043286f
C106 VCC.n50 GND 0.006506f
C107 VCC.n51 GND 0.008679f
C108 VCC.t11 GND 0.008258f
C109 VCC.n52 GND 0.003736f
C110 VCC.n53 GND 0.006755f
C111 VCC.n54 GND 0.006755f
C112 VCC.t6 GND 0.059068f
C113 VCC.n55 GND 0.006509f
C114 VCC.n57 GND 0.043286f
C115 VCC.n58 GND 0.006755f
C116 VCC.n60 GND 0.043286f
C117 VCC.n61 GND 0.006502f
C118 VCC.n62 GND 0.004941f
C119 VCC.t7 GND 0.008275f
C120 VCC.n63 GND 0.135496f
C121 VCC.n64 GND 0.137211f
C122 VCC.n65 GND 0.188971f
C123 VCC.n66 GND 0.138433f
C124 VCC.n67 GND 0.19481f
C125 VCC.n68 GND 0.474145f
C126 VCC.n69 GND 0.474762f
C127 VCC.n70 GND 0.194856f
C128 VCC.n71 GND 0.138388f
C129 VCC.n72 GND 0.188925f
C130 VCC.n73 GND 0.137211f
C131 VCC.n74 GND 0.144518f
C132 VCC.t1 GND 0.008275f
C133 VCC.n75 GND 0.006508f
C134 VCC.n76 GND 0.006755f
C135 VCC.n77 GND 0.006755f
C136 VCC.t0 GND 0.059068f
C137 VCC.n79 GND 0.043286f
C138 VCC.n80 GND 0.006755f
C139 VCC.n82 GND 0.043286f
C140 VCC.n83 GND 0.006509f
C141 VCC.n84 GND 0.008672f
C142 VCC.t15 GND 0.008258f
C143 VCC.n85 GND 0.00375f
C144 VCC.n86 GND 0.006755f
C145 VCC.n87 GND 0.006755f
C146 VCC.t14 GND 0.059068f
C147 VCC.n89 GND 0.006506f
C148 VCC.n90 GND 0.043286f
C149 VCC.n91 GND 0.006755f
C150 VCC.n93 GND 0.043286f
C151 VCC.n94 GND 0.0065f
C152 VCC.n95 GND 0.004935f
C153 VCC.t17 GND 0.008275f
C154 VCC.n96 GND 0.00375f
C155 VCC.n97 GND 0.006755f
C156 VCC.n98 GND 0.006755f
C157 VCC.t16 GND 0.059068f
C158 VCC.n100 GND 0.006506f
C159 VCC.n101 GND 0.043286f
C160 VCC.n102 GND 0.006755f
C161 VCC.n104 GND 0.043286f
C162 VCC.n105 GND 0.0065f
C163 VCC.n106 GND 0.004976f
C164 VCC.n107 GND 0.006505f
C165 VCC.n108 GND 0.006755f
C166 VCC.n109 GND 0.006755f
C167 VCC.t22 GND 0.059068f
C168 VCC.n111 GND 0.043286f
C169 VCC.n112 GND 0.006755f
C170 VCC.n114 GND 0.043286f
C171 VCC.n115 GND 0.006506f
C172 VCC.n116 GND 0.00872f
C173 VCC.t23 GND 0.008275f
C174 VCC.n117 GND 0.006505f
C175 VCC.n118 GND 0.006755f
C176 VCC.n119 GND 0.006755f
C177 VCC.t2 GND 0.059068f
C178 VCC.n121 GND 0.043286f
C179 VCC.n122 GND 0.006755f
C180 VCC.n124 GND 0.043286f
C181 VCC.n125 GND 0.006506f
C182 VCC.n126 GND 0.008679f
C183 VCC.t3 GND 0.008258f
C184 VCC.n127 GND 0.003736f
C185 VCC.n128 GND 0.006755f
C186 VCC.n129 GND 0.006755f
C187 VCC.t8 GND 0.059068f
C188 VCC.n131 GND 0.006509f
C189 VCC.n132 GND 0.043286f
C190 VCC.n133 GND 0.006755f
C191 VCC.n135 GND 0.043286f
C192 VCC.n136 GND 0.006502f
C193 VCC.n137 GND 0.004941f
C194 VCC.t9 GND 0.008275f
C195 VCC.n138 GND 0.135496f
C196 VCC.n139 GND 0.137211f
C197 VCC.n140 GND 0.188971f
C198 VCC.n141 GND 0.138433f
C199 VCC.n142 GND 0.19481f
C200 VCC.n143 GND 0.47395f
C201 VCC.n144 GND 0.476039f
C202 VCC.n145 GND 0.194856f
C203 VCC.n146 GND 0.138388f
C204 VCC.n147 GND 0.188925f
C205 VCC.n148 GND 0.137211f
C206 VCC.n149 GND 0.144597f
C207 VCC.n150 GND 1.16683f
C208 a_1485_n12542.t2 GND 0.053229f
C209 a_1485_n12542.t4 GND 0.029072f
C210 a_1485_n12542.t3 GND 0.027802f
C211 a_1485_n12542.n0 GND 0.762929f
C212 a_1485_n12542.n1 GND 0.693256f
C213 a_1485_n12542.t1 GND 0.036788f
C214 a_1485_n12542.n2 GND 0.844022f
C215 a_1485_n12542.t0 GND 0.052902f
C216 a_1507_n2149.t3 GND 0.029069f
C217 a_1507_n2149.t4 GND 0.027802f
C218 a_1507_n2149.n0 GND 0.762932f
C219 a_1507_n2149.t1 GND 0.036788f
C220 a_1507_n2149.t2 GND 0.052902f
C221 a_1507_n2149.n1 GND 0.844022f
C222 a_1507_n2149.n2 GND 0.693255f
C223 a_1507_n2149.t0 GND 0.053229f
.ends
