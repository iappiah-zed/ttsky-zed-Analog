* NGSPICE file created from ic_7804_AND.ext - technology: sky130A

.subckt sky130_fd_pr__nfet_01v8_648S5X a_n73_n100# a_n33_n188# a_15_n100# a_n175_n274#
X0 a_15_n100# a_n33_n188# a_n73_n100# a_n175_n274# sky130_fd_pr__nfet_01v8 ad=0.29 pd=2.58 as=0.29 ps=2.58 w=1 l=0.15
.ends

.subckt sky130_fd_pr__pfet_01v8_XGAKDL a_15_n200# w_n211_n419# a_n33_n297# a_n73_n200#
X0 a_15_n200# a_n33_n297# a_n73_n200# w_n211_n419# sky130_fd_pr__pfet_01v8 ad=0.58 pd=4.58 as=0.58 ps=4.58 w=2 l=0.15
.ends

.subckt ic_7804_AND A B Y VCC GND
XXM1 m1_1645_n1911# A m1_914_51# GND sky130_fd_pr__nfet_01v8_648S5X
XXM2 m1_914_51# VCC A VCC sky130_fd_pr__pfet_01v8_XGAKDL
XXM3 m1_914_51# VCC B VCC sky130_fd_pr__pfet_01v8_XGAKDL
XXM4 GND B m1_1645_n1911# GND sky130_fd_pr__nfet_01v8_648S5X
XXM5 Y VCC m1_914_51# VCC sky130_fd_pr__pfet_01v8_XGAKDL
XXM6 GND m1_914_51# Y GND sky130_fd_pr__nfet_01v8_648S5X
.ends
