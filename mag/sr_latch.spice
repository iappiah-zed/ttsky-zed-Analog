* NGSPICE file created from sr_latch.ext - technology: sky130A

.subckt sky130_fd_pr__pfet_01v8_XJP3BL a_15_n150# w_n211_n369# a_n73_n150# a_n33_n247#
X0 a_15_n150# a_n33_n247# a_n73_n150# w_n211_n369# sky130_fd_pr__pfet_01v8 ad=0.435 pd=3.58 as=0.435 ps=3.58 w=1.5 l=0.15
.ends

.subckt sky130_fd_pr__nfet_01v8_CSX3TK a_n33_n163# a_15_n75# a_n175_n249# a_n73_n75#
X0 a_15_n75# a_n33_n163# a_n73_n75# a_n175_n249# sky130_fd_pr__nfet_01v8 ad=0.2175 pd=2.08 as=0.2175 ps=2.08 w=0.75 l=0.15
.ends

.subckt nor_gate vdd a y b vss
XXM1 m1_1722_n432# vdd vdd a sky130_fd_pr__pfet_01v8_XJP3BL
XXM2 y vdd m1_1722_n432# b sky130_fd_pr__pfet_01v8_XJP3BL
XXM3 a y vss vss sky130_fd_pr__nfet_01v8_CSX3TK
XXM4 b y vss vss sky130_fd_pr__nfet_01v8_CSX3TK
.ends

.subckt sr_latch vdd s qb q vss r
Xx1 vdd s q qb vss nor_gate
Xx2 vdd q qb r vss nor_gate
.ends
